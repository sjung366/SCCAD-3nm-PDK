.LIB TT

**********************************************
*   3-nm-node FinFET                         *
**********************************************
.MODEL NMOS_RVT NMOS ( LEVEL =72
************************************************************
*                         general                          *
************************************************************
+version = 110             bulkmod = 1               igcmod  = 0               igbmod  = 0
+gidlmod = 0               iimod   = 0               geomod  = 2               rdsmod  = 0
+rgatemod= 0               rgeomod = 0               shmod   = 0               nqsmod  = 0
+coremod = 0               cgeomod = 0               capmod  = 1               tnom    = 25
+eot     = 0.795e-009      eotbox  = 1.0e-007        eotacc  = 0.795e-009      tfin    = 2.0e-008
+toxp    = 1.7e-009        nbody   = 1e+021          epsrox  = 3.9             hfin    = 4.5e-008
+epsrsub = 11.9            easub   = 4.05            ni0sub  = 1.1e+016        bg0sub  = 1.12
+nc0sub  = 2.86e+025       nsd     = 4e+026          sdterm  = 0               nf      = 1
+l       = 1.2e-008        lsp     = 5.0e-9          epsrsp  = 3.9             nfin    = 3
+fpitch  = 2.0e-008	   type=1
************************************************************
*                            dc                            *
************************************************************
+cit     = 0               rdsw =  1.384165e+01		     phig =  4.231052        cdsc =    2.750617e-03
+dvt0    = 0.00            dvt1    = 0.60            u0 = 3.994096e-02       ua = 3.189484e+01
+phin    = 0.05            dsub    = 3.260404e+01    etamob = 3.53125	       eu =  0
+k1rsce  = 0               lpe0    = 0               dvtshift= 0              qmfactor= 0.0
+etaqm   = 0.54            qm0 =   8.80479e-02       ud = 0.3		       vsat = 7.030000e+04
+ucs = 1.561801e+01        cdscd =  1.000000e-11     eta0 =  3.571000e-01     mexp=4.174087
+up      = 0               ksativ = 4.921315e-01     dsub =  2.575837e+01     ptwg =  -1.185173e+01
+rshs    = 0               dvtp0 =  -1.823340e-02    pvag =  25.8	       pdibl2 =  -0.05
+rshd    = 0               deltavsat= 0.28           vsat1 = 4.600000e+05
+pclm    = 0.013           pclmg   = 0
+pdibl1  = 1.3             drout   = 1.06
+rth0    = 0.01            cth0    = 1.0e-5          wth0    = 0.0
************************************************************
*                         leakage                          *
************************************************************
+aigc    = 0.0136          bigc    = 0.00171         cigc    = 0.075           dlcigs  = 0.0
+dlcigd  = 0.0             aigs    = 0.0136          aigd    = 0.0136          bigs    = 0.00171
+bigd    = 0.00171         cigs    = 0.075           cigd    = 0.075           poxedge = 1
+agidl   = 6.055e-012      agisl   = 6.055e-012      bgidl   = 0.3e+9          bgisl   = 0.3e+9
+egidl   = 0.2             egisl   = 0.2
************************************************************
*                            rf                            *
************************************************************
+
************************************************************
*                         junction                         *
************************************************************
************************************************************
*                       capacitance                        *
************************************************************
+cfs =  5.21125e-13 	   cfd = 5.21125e-13    cgso =  5.94030e-13           cgbo = 1.04819e-11
+cgbl =  1.24624e-09      qmtcencv = 5.05598	ckappas =  15		 ckappad =  15
+cgsl =  3.14179e-11      cgdl = 2.40393e-11    pqm = 1.16706              pclmcv = 5.00000e-04
+deltawcv = -5.49129e-13  cgdo = 5.62643e-11

************************************************************
*                       temperature                        *
************************************************************
************************************************************
*                          noise                           *
************************************************************

)

.MODEL PMOS_RVT PMOS ( LEVEL=72
************************************************************
*                         general                          *
************************************************************
+version = 110             bulkmod = 1               igcmod  = 0               igbmod  = 0
+gidlmod = 0               iimod   = 0               geomod  = 2               rdsmod  = 0
+rgatemod= 0               rgeomod = 0               shmod   = 0               nqsmod  = 0
+coremod = 0               cgeomod = 0               capmod  = 1               tnom    = 25
+eot     = 0.795e-009      eotbox  = 1.0e-007        eotacc  = 0.795e-009      tfin    = 2.0e-008
+toxp    = 1.7e-009        nbody   = 1e+021          epsrox  = 3.9             hfin    = 3.5e-008
+epsrsub = 11.9            easub   = 4.05            ni0sub  = 1.1e+016        bg0sub  = 1.12
+nc0sub  = 2.86e+025       nsd     = 4e+026          sdterm  = 0               nf      = 1
+l       = 1.2e-008        lsp     = 5.0e-9          epsrsp  = 3.9             nfin    = 3
+fpitch  = 6.0e-008        type=-1
************************************************************
*                            dc      4.654964                    *
************************************************************
+cit     = 0               rdsw =  3.569246e+02      phig = 4.777964           cdsc=  2.657889e-03
+dvt0    = 0.00            dvt1    = 0.60            u0 = 9.966630e-03        ua =  2.867087e-01
+phin    = 0.05            dsub    = 1.417540e+02    etamob =1.000000e+02      eu =  5.853179e-01
+k1rsce  = 0               lpe0    = 0               dvtshift= 0               qmfactor= 0.0
+etaqm   = 0.54            qm0     =  1.50942    ucs = 8.813972	      cdscd= 0
+pqm     =  40             ud = 8.738093e-03	     eta0 = 7.000000e-01     vsat =  9.065021e+04
+up      = 0               ksativ = 1.238147       ptwg = 4.316449        dvtp0 = -1.151960e-02
+rshs    = 0               pvag = 6.006475	      pdibl2 = -1.640818e-01   mexp =1.194201
+rshd    = 0               deltavsat= 0.28           vsat1 =  9.066663e+04
+pclm    = 0.013           pclmg   = 0               pclmcv = 1.71176e-01
+pdibl1  = 1.3             drout   = 1.06
+rth0    = 0.01            cth0    = 1.0e-5          wth0    = 0.0
************************************************************
*                         leakage                          *
************************************************************
+aigc    = 0.0136          bigc    = 0.00171         cigc    = 0.075           dlcigs  = 0.0
+dlcigd  = 0.0             aigs    = 0.0136          aigd    = 0.0136          bigs    = 0.00171
+bigd    = 0.00171         cigs    = 0.075           cigd    = 0.075           poxedge = 1
+agidl   = 6.055e-012      agisl   = 6.055e-012      bgidl   = 0.3e+9          bgisl   = 0.3e+9
+egidl   = 0.2             egisl   = 0.2
************************************************************
*                            rf                            *
************************************************************
************************************************************
*                         junction                         *
************************************************************
************************************************************
*                       capacitance                        *
************************************************************
+cfs	=  7.32656e-12	cgso = 0	cgdo =  0	cgsl =  1.03723e-10
+cgdl = 1.12177e-10 	qmtcencv = 2.30432e-03  ckappas =  6.22815e-01  ckappad =   2.00000e-02
+cfd = 1.07333e-10      cgbo = 1.37249e-11      cgbl =  1.50389e-09    	deltawcv =   5.29316e-08
************************************************************
*                       temperature                        *
************************************************************
************************************************************
*                          noise                           *
************************************************************
)

.ENDL TT
